# Ansys Electronics Desktop project, version 2022.1
materials:
  vacuum: permittivity=1
  N48H_AM: thermal_modifier{Property=permeability free_form_value="1 - 0.0012*(Temp - 20)"} thermal_modifier{Property=magnetic_coercivity free_form_value="1 - 0.00605*(Temp - 20)"} permeability{BTypeForSingleCurve=intrinsic HUnit=A_per_meter BUnit=tesla curve (-1353000, 0) (-1352683.2, 0.024903605) (-1352359.1, 0.049905196) (-1352027.3, 0.074993874) (-1351687.8, 0.10015836) (-1351340.3, 0.12538701) (-1350984.7, 0.1506678) (-1350620.8, 0.17598834) (-1350248.3, 0.20133591) (-1349867.1, 0.22669744) (-1349477, 0.25205952) (-1349077.8, 0.27740844) (-1348669.2, 0.3027302) (-1348251.1, 0.32801049) (-1347823.1, 0.35323477) (-1347385.2, 0.37838823) (-1346937, 0.40345586) (-1346478.3, 0.42842243) (-1346008.8, 0.45327255) (-1345528.4, 0.47799068) (-1345036.7, 0.50256117) (-1344533.5, 0.52696827) (-1344018.6, 0.55119616) (-1343491.5, 0.57522903) (-1342952.2, 0.59905104) (-1342400.2, 0.62264642) (-1341835.3, 0.64599947) (-1341257.1, 0.66909461) (-1340665.5, 0.69191642) (-1340059.9, 0.71444969) (-1339440.2, 0.73667942) (-1338806, 0.75859091) (-1338157, 0.78016978) (-1337492.7, 0.80140202) (-1336812.9, 0.82227401) (-1336117.2, 0.84277261) (-1335405.2, 0.86288515) (-1334676.5, 0.8825995) (-1333930.8, 0.9019041) (-1333167.6, 0.92078803) (-1332386.5, 0.939241) (-1331587.2, 0.95725344) (-1330769.1, 0.97481649) (-1329931.9, 0.99192207) (-1329075.1, 1.0085629) (-1328198.2, 1.0247325) (-1327300.8, 1.0404253) (-1326382.4, 1.0556365) (-1325442.5, 1.0703624) (-1324480.6, 1.0846) (-1323496.1, 1.0983474) (-1322488.7, 1.1116036) (-1321457.6, 1.1243684) (-1320402.4, 1.1366428) (-1319322.5, 1.1484287) (-1318217.3, 1.1597287) (-1317086.2, 1.1705467) (-1315928.6, 1.1808873) (-1314744, 1.1907561) (-1313531.6, 1.2001594) (-1312290.9, 1.2091046) (-1311021, 1.2175997) (-1309721.5, 1.2256537) (-1308391.5, 1.2332762) (-1307030.4, 1.2404775) (-1305637.5, 1.2472686) (-1304211.9, 1.253661) (-1302752.9, 1.259667) (-1301259.8, 1.2652991) (-1299731.7, 1.2705703) (-1298167.9, 1.2754941) (-1296567.4, 1.2800841) (-1294929.5, 1.2843545) (-1293253.3, 1.2883192) (-1291537.7, 1.2919926) (-1289782.1, 1.295389) (-1287985.3, 1.2985228) (-1286146.5, 1.3014081) (-1284264.6, 1.3040591) (-1282338.6, 1.3064899) (-1280367.6, 1.308714) (-1278350.4, 1.3107451) (-1276286, 1.3125961) (-1274173.2, 1.3142799) (-1272011, 1.3158089) (-1269798.2, 1.3171949) (-1267533.6, 1.3184494) (-1265216, 1.319583365) (-1262844.1, 1.3206073) (-1260416.6, 1.321531) (-1257932.4, 1.322364) (-1255389.9, 1.3231151) (-1252788, 1.3237925) (-1250125.1, 1.3244041) (-1247399.9, 1.3249571) (-1244610.9, 1.3254581) (-1241756.6, 1.3259134) (-1238835.5, 1.3263286) (-1235846, 1.3267088) (-1232786.5, 1.327059) (-1229655.4, 1.3273833) (-1226451, 1.3276856) (-1223171.5, 1.3279694) (-1219815.3, 1.3282379) (-1216380.5, 1.3284939) (-1212865.3, 1.3287399) (-1209267.8, 1.3289779) (-1205586, 1.3292101) (-1201818.1, 1.3294381) (-1197962, 1.3296633) (-1194015.6, 1.3298871) (-1189976.8, 1.3301106) (-1185843.4, 1.3303347) (-1181613.3, 1.3305604) (-1177284.1, 1.3307884) (-1172853.6, 1.3310192) (-1168319.4, 1.3312535) (-1163679, 1.3314917) (-1158930, 1.3317342) (-1154069.7, 1.3319815)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} conductivity=498314.1782 magnetic_coercivity{Magnitude=-1063583.5A_per_meter DirComp1=1 DirComp2=0 DirComp3=0}
  Copper (Annealed)_20C: conductivity=58004640
  M250-35A_20C: permeability{HUnit=A_per_meter BUnit=tesla curve (0, 0) (12, 0.1) (24, 0.2) (36, 0.3) (48, 0.4) (60, 0.5) (72, 0.6) (84, 0.7) (96, 0.8) (109, 0.9) (128, 1) (155, 1.1) (200, 1.2) (295, 1.3) (578, 1.4) (1567, 1.5) (3673, 1.6) (6996, 1.7) (13134.9088, 1.8162) (28200.2369, 1.8924) (100790, 1.998) (180370, 2.1) (259950, 2.2) (339530, 2.3) (419110, 2.4) (498690, 2.5)} conductivity=1694915.3 core_loss_type="Electrical Steel" core_loss_kh=187.425 core_loss_kc=0.34153292 mass_density=7650 stacking_type=Lamination stacking_factor=0.97 stacking_direction=V(3)

design Motor-CAD 20p_24s (Maxwell 2D, Transient, XY geometry, model units mm)
options: ModelDepth=Magnetic_Axial_Length
variables:
  DiaGap = 60mm
  DiaStatorYoke = 100mm
  DiaShaft = 19.7002mm
  DiaOuter = 100mm
  Airgap = 0.8mm
  StatorSkewAngle = 0deg
  Model_Length = 0mm
  Magnet_Length = 60mm
  Stator_Lam_Length = 0mm
  Rotor_Lam_Length = 0mm
  RotorDia = 58.4mm
  Rotor_Slices = 1
  SlotNumber_Stator = 24
  SlotType_Stator = 3
  Hs0_Stator = 1mm
  Hs1_Stator = 0.21328386mm
  Hs2_Stator = 13.614096mm
  Bs0_Stator = 2.25511mm
  Bs1_Stator = 3.1698874mm
  Bs2_Stator = 6.754547mm
  Rs_Stator = 1mm
  Magnetic_Axial_Length = 60mm
  Layers = 1
  ParallelPaths = 4
  WdgExt_F = 4mm
  SpanExt = 14mm
  HalfAxial = 0
  SymmetryFactor = 4
  SegAngle = 0deg
  NumPoles = 20
  Magnet_Axial_Offset = 0mm
  Axial_Segments = 2
  Shaft_Hole_Diameter = 0mm
  Sleeve_Thickness = 0mm
  Banding_Thickness = 0mm
  IPeak = 102.58885A
  PhaseAdvance = 0deg
  MachineRPM = 10000rpm
  NumTorqueCycles = 1
  NumTorquePointsPerCycle = 60
  DriveOffsetED = 60deg
  InitialPositionMD = DriveOffsetED / (NumPoles/2)
geometry:
  Stator [M250-35A_20C] = polyline(z=0mm, xy in mm: (50, 0) (35.355339, 35.355339) (3.061617e-15, 50) (0, 30) (1.3990774, 29.967359) (2.7951102, 29.869505) (2.9256366, 30.86095) (2.5, 31.132111) (2.5, 44.863682) (2.8209484, 45.597773) (3.5777778, 45.860653) (6.0042046, 45.606464) (8.413742, 45.223986) (9.0767449, 44.774182) (9.196761, 43.982038) (5.6427686, 30.718357) (5.1614538, 30.566599) (5.0309276, 29.575155) (7.7645712, 28.977775) (10.430666, 28.128299) (10.81335, 29.052179) (10.472398, 29.424262) (14.02639, 42.687942) (14.526399, 43.313951) (15.325478, 43.371992) (17.603438, 42.498459) (19.83188, 41.50538) (20.355873, 40.899304) (20.266778, 40.103089) (13.400992, 28.211199) (12.8968, 28.189185) (12.514116, 27.265306) (15, 25.980762) (17.355389, 24.470196) (17.964151, 25.263549) (17.731119, 25.711199) (24.596905, 37.603089) (25.241899, 38.078356) (26.028773, 37.927602) (28.003026, 36.494254) (29.898508, 34.95825) (30.247783, 34.237207) (29.955647, 33.491181) (20.24596, 23.781494) (19.75325, 23.890725) (19.144488, 23.097371) (21.213203, 21.213204) (23.097371, 19.144489) (23.890725, 19.75325) (23.781494, 20.24596) (33.491181, 29.955647) (34.237206, 30.247783) (34.95825, 29.898508) (36.494254, 28.003026) (37.927601, 26.028773) (38.078356, 25.2419) (37.603089, 24.596905) (25.711199, 17.731119) (25.263549, 17.964151) (24.470195, 17.355389) (25.980762, 15) (27.265306, 12.514116) (28.189185, 12.8968) (28.211199, 13.400992) (40.103089, 20.266778) (40.899304, 20.355874) (41.50538, 19.83188) (42.498458, 17.603438) (43.371992, 15.325479) (43.313952, 14.526399) (42.687942, 14.02639) (29.424262, 10.472398) (29.052179, 10.81335) (28.128299, 10.430666) (28.977775, 7.7645714) (29.575155, 5.0309277) (30.566599, 5.1614538) (30.718357, 5.6427686) (43.982037, 9.1967609) (44.774182, 9.0767452) (45.223986, 8.4137425) (45.606464, 6.0042048) (45.860653, 3.5777778) (45.597773, 2.8209484) (44.863682, 2.5) (31.132111, 2.5) (30.86095, 2.9256366) (29.869505, 2.7951104) (29.967359, 1.3990774) (30, -2.5868196e-12) (50, 0), closed, covered, AngularArc from point 0 over 3 centre=(0mm, 0mm, 0mm) angle=90deg plane=XY, AngularArc from point 3 over 3 centre=(0mm, 0mm, 0mm) angle=-5.346021deg plane=XY, AngularArc from point 8 over 3 centre=(3.5mm, 44.863682mm, 0mm) angle=-94.460844deg plane=XY, AngularArc from point 10 over 3 centre=(0mm, 0mm, 0mm) angle=-6.078312deg plane=XY, AngularArc from point 12 over 3 centre=(8.2308351mm, 44.240856mm, 0mm) angle=-94.460844deg plane=XY, AngularArc from point 17 over 3 centre=(0mm, 0mm, 0mm) angle=-10.692042deg plane=XY, AngularArc from point 22 over 3 centre=(14.992316mm, 42.429123mm, 0mm) angle=-94.460844deg plane=XY, AngularArc from point 24 over 3 centre=(0mm, 0mm, 0mm) angle=-6.078312deg plane=XY, AngularArc from point 26 over 3 centre=(19.400752mm, 40.603089mm, 0mm) angle=-94.460844deg plane=XY, AngularArc from point 31 over 3 centre=(0mm, 0mm, 0mm) angle=-10.692042deg plane=XY, AngularArc from point 36 over 3 centre=(25.46293mm, 37.103089mm, 0mm) angle=-94.460844deg plane=XY, AngularArc from point 38 over 3 centre=(0mm, 0mm, 0mm) angle=-6.078312deg plane=XY, AngularArc from point 40 over 3 centre=(29.24854mm, 34.198288mm, 0mm) angle=-94.460844deg plane=XY, AngularArc from point 45 over 3 centre=(0mm, 0mm, 0mm) angle=-10.692042deg plane=XY, AngularArc from point 50 over 3 centre=(34.198288mm, 29.24854mm, 0mm) angle=-94.460844deg plane=XY, AngularArc from point 52 over 3 centre=(0mm, 0mm, 0mm) angle=-6.078312deg plane=XY, AngularArc from point 54 over 3 centre=(37.103089mm, 25.46293mm, 0mm) angle=-94.460844deg plane=XY, AngularArc from point 59 over 3 centre=(0mm, 0mm, 0mm) angle=-10.692042deg plane=XY, AngularArc from point 64 over 3 centre=(40.603089mm, 19.400752mm, 0mm) angle=-94.460844deg plane=XY, AngularArc from point 66 over 3 centre=(0mm, 0mm, 0mm) angle=-6.078312deg plane=XY, AngularArc from point 68 over 3 centre=(42.429123mm, 14.992316mm, 0mm) angle=-94.460844deg plane=XY, AngularArc from point 73 over 3 centre=(0mm, 0mm, 0mm) angle=-10.692042deg plane=XY, AngularArc from point 78 over 3 centre=(44.240856mm, 8.2308351mm, 0mm) angle=-94.460844deg plane=XY, AngularArc from point 80 over 3 centre=(0mm, 0mm, 0mm) angle=-6.0783126deg plane=XY, AngularArc from point 82 over 3 centre=(44.863682mm, 3.5mm, 0mm) angle=-94.460844deg plane=XY, AngularArc from point 87 over 3 centre=(0mm, 0mm, 0mm) angle=-5.3460212deg plane=XY)
  Shaft [vacuum] = polyline(z=0mm, xy in mm: (9.8501, 0) (6.9650725, 6.9650725) (6.0314467e-16, 9.8501) (0, 0) (9.8501, 0), closed, covered, AngularArc from point 0 over 3 centre=(0mm, 0mm, 0mm) angle=90deg plane=XY)
  Rotor_1 [M250-35A_20C] = polyline(z=0mm, xy in mm: (9.8501, 2.1871616e-15) (26.2, 0) (18.526198, 18.526198) (1.6042873e-15, 26.2) (0, 9.8501) (6.9650725, 6.9650725) (9.8501, 2.1871616e-15), closed, covered, AngularArc from point 1 over 3 centre=(0mm, 0mm, 0mm) angle=90deg plane=XY, AngularArc from point 4 over 3 centre=(0mm, 0mm, 0mm) angle=-90deg plane=XY)
  RotorAir [vacuum] = polyline(z=0mm, xy in mm: (26.2, -5.6035732e-13) (29.2, 0) (29.199722, 0.12740863) (29.198888, 0.25481484) (26.199002, 0.22863523) (26.199751, 0.1143187) (26.2, -5.6035732e-13), closed, covered, AngularArc from point 1 over 3 centre=(0mm, 0mm, 0mm) angle=0.5deg plane=XY, AngularArc from point 4 over 3 centre=(0mm, 0mm, 0mm) angle=-0.5deg plane=XY)
  coordinate_system CS_1Magnet1N1_1_1 = origin=(27.358967mm, 4.3332347mm, 0mm) x=(1.3728868mm, 0.21744391mm, 0mm) y=(-0.21744391mm, 1.3728868mm, 0mm)
  1Magnet1N1_1_1 [N48H_AM, oriented by CS_1Magnet1N1_1_1] = polyline(z=0mm, xy in mm: (26.199002, 0.22863523) (29.198888, 0.25481484) (28.8405, 4.5678864) (27.848535, 8.7806093) (24.987384, 7.8784919) (25.877435, 4.098583) (26.199002, 0.22863523), closed, covered, AngularArc from point 1 over 3 centre=(0mm, 0mm, 0mm) angle=17deg plane=XY, AngularArc from point 4 over 3 centre=(0mm, 0mm, 0mm) angle=-17deg plane=XY)
  RotorAir_1 [vacuum] = polyline(z=0mm, xy in mm: (24.987384, 7.8784919) (27.848535, 8.7806093) (27.809957, 8.9020375) (27.77085, 9.0232962) (24.917681, 8.0962453) (24.95277, 7.9874446) (24.987384, 7.8784919), closed, covered, AngularArc from point 1 over 3 centre=(0mm, 0mm, 0mm) angle=0.5deg plane=XY, AngularArc from point 4 over 3 centre=(0mm, 0mm, 0mm) angle=-0.5deg plane=XY)
  RotorAir_2 [vacuum] = polyline(z=0mm, xy in mm: (24.917681, 8.0962453) (27.77085, 9.0232962) (27.731214, 9.1443831) (27.691051, 9.265296) (24.84608, 8.313382) (24.882117, 8.2048917) (24.917681, 8.0962453), closed, covered, AngularArc from point 1 over 3 centre=(0mm, 0mm, 0mm) angle=0.5deg plane=XY, AngularArc from point 4 over 3 centre=(0mm, 0mm, 0mm) angle=-0.5deg plane=XY)
  coordinate_system CS_1Magnet1S2_1_1 = origin=(24.68088072mm, 12.575537mm, 0mm) x=(-1.2384991mm, -0.63104679mm, 0mm) y=(0.63104679mm, -1.2384991mm, 0mm)
  1Magnet1S2_1_1 [N48H_AM, oriented by CS_1Magnet1S2_1_1] = polyline(z=0mm, xy in mm: (24.84608, 8.313382) (27.691051, 9.265296) (26.017391, 13.256523) (23.772173, 16.956526) (21.329827, 15.214417) (23.344371, 11.894551) (24.84608, 8.313382), closed, covered, AngularArc from point 1 over 3 centre=(0mm, 0mm, 0mm) angle=17deg plane=XY, AngularArc from point 4 over 3 centre=(0mm, 0mm, 0mm) angle=-17deg plane=XY)
  RotorAir_3 [vacuum] = polyline(z=0mm, xy in mm: (21.329827, 15.214417) (23.772173, 16.956526) (23.69796, 17.06009) (23.623296, 17.163329) (21.196245, 15.399974) (21.263238, 15.307341) (21.329827, 15.214417), closed, covered, AngularArc from point 1 over 3 centre=(0mm, 0mm, 0mm) angle=0.5deg plane=XY, AngularArc from point 4 over 3 centre=(0mm, 0mm, 0mm) angle=-0.5deg plane=XY)
  RotorAir_4 [vacuum] = polyline(z=0mm, xy in mm: (21.196245, 15.399974) (23.623296, 17.163329) (23.548182, 17.266242) (23.47262, 17.368825) (21.06105, 15.584357) (21.128849, 15.492313) (21.196245, 15.399974), closed, covered, AngularArc from point 1 over 3 centre=(0mm, 0mm, 0mm) angle=0.5deg plane=XY, AngularArc from point 4 over 3 centre=(0mm, 0mm, 0mm) angle=-0.5deg plane=XY)
  coordinate_system CS_1Magnet1N2_1_1 = origin=(19.586858mm, 19.586858mm, 0mm) x=(0.98287843mm, 0.98287843mm, 0mm) y=(-0.98287843mm, 0.98287843mm, 0mm)
  1Magnet1N2_1_1 [N48H_AM, oriented by CS_1Magnet1N2_1_1] = polyline(z=0mm, xy in mm: (21.06105, 15.584357) (23.47262033, 17.368825) (20.647518, 20.647518) (17.368825, 23.47262) (15.584357, 21.06105) (18.526198, 18.526198) (21.06105, 15.584357), closed, covered, AngularArc from point 1 over 3 centre=(0mm, 0mm, 0mm) angle=17deg plane=XY, AngularArc from point 4 over 3 centre=(0mm, 0mm, 0mm) angle=-17deg plane=XY)
  RotorAir_5 [vacuum] = polyline(z=0mm, xy in mm: (15.584357, 21.06105) (17.368825, 23.47262033) (17.266242, 23.548182) (17.163329, 23.623296) (15.399974, 21.196245) (15.492313, 21.128849) (15.584357, 21.06105), closed, covered, AngularArc from point 1 over 3 centre=(0mm, 0mm, 0mm) angle=0.5deg plane=XY, AngularArc from point 4 over 3 centre=(0mm, 0mm, 0mm) angle=-0.5deg plane=XY)
  RotorAir_6 [vacuum] = polyline(z=0mm, xy in mm: (15.399974, 21.196245) (17.163329, 23.623296) (17.06009, 23.69796) (16.956526, 23.772173) (15.214417, 21.329827) (15.307341, 21.263238) (15.399974, 21.196245), closed, covered, AngularArc from point 1 over 3 centre=(0mm, 0mm, 0mm) angle=0.5deg plane=XY, AngularArc from point 4 over 3 centre=(0mm, 0mm, 0mm) angle=-0.5deg plane=XY)
  coordinate_system CS_1Magnet1S3_1_1 = origin=(12.575537mm, 24.68088072mm, 0mm) x=(-0.63104679mm, -1.2384991mm, 0mm) y=(1.2384991mm, -0.63104679mm, 0mm)
  1Magnet1S3_1_1 [N48H_AM, oriented by CS_1Magnet1S3_1_1] = polyline(z=0mm, xy in mm: (15.214417, 21.329827) (16.956526, 23.772173) (13.256523, 26.017391) (9.265296, 27.691051) (8.313382, 24.84608) (11.894551, 23.344371) (15.214417, 21.329827), closed, covered, AngularArc from point 1 over 3 centre=(0mm, 0mm, 0mm) angle=17deg plane=XY, AngularArc from point 4 over 3 centre=(0mm, 0mm, 0mm) angle=-17deg plane=XY)
  RotorAir_7 [vacuum] = polyline(z=0mm, xy in mm: (8.313382, 24.84608) (9.265296, 27.691051) (9.1443831, 27.731214) (9.0232962, 27.77085) (8.0962453, 24.917681) (8.2048917, 24.882117) (8.313382, 24.84608), closed, covered, AngularArc from point 1 over 3 centre=(0mm, 0mm, 0mm) angle=0.5deg plane=XY, AngularArc from point 4 over 3 centre=(0mm, 0mm, 0mm) angle=-0.5deg plane=XY)
  RotorAir_8 [vacuum] = polyline(z=0mm, xy in mm: (8.0962453, 24.917681) (9.0232962, 27.77085) (8.9020375, 27.809957) (8.7806093, 27.848535) (7.8784919, 24.987384) (7.9874446, 24.95277) (8.0962453, 24.917681), closed, covered, AngularArc from point 1 over 3 centre=(0mm, 0mm, 0mm) angle=0.5deg plane=XY, AngularArc from point 4 over 3 centre=(0mm, 0mm, 0mm) angle=-0.5deg plane=XY)
  RotorAir_9 [vacuum] = polyline(z=0mm, xy in mm: (0, 26.2) (0.1143187, 26.199751) (0.22863523, 26.199002) (0.25481484, 29.198888) (0.12740863, 29.199722) (2.5823788e-13, 29.2) (0, 26.2), closed, covered, AngularArc from point 0 over 3 centre=(0mm, 0mm, 0mm) angle=-0.5deg plane=XY, AngularArc from point 3 over 3 centre=(0mm, 0mm, 0mm) angle=0.5deg plane=XY)
  coordinate_system CS_1Magnet1N3_1_1 = origin=(4.3332347mm, 27.358967mm, 0mm) x=(0.21744391mm, 1.3728868mm, 0mm) y=(-1.3728868mm, 0.21744391mm, 0mm)
  1Magnet1N3_1_1 [N48H_AM, oriented by CS_1Magnet1N3_1_1] = polyline(z=0mm, xy in mm: (7.8784919, 24.987384) (8.7806093, 27.848535) (4.5678864, 28.8405) (0.25481484, 29.198888) (0.22863523, 26.199002) (4.098583, 25.877435) (7.8784919, 24.987384), closed, covered, AngularArc from point 1 over 3 centre=(0mm, 0mm, 0mm) angle=17deg plane=XY, AngularArc from point 4 over 3 centre=(0mm, 0mm, 0mm) angle=-17deg plane=XY)
  Rotating_Band_mid [vacuum] = user_primitive(RMxprt/Band.dll, DiaGap=DiaGap - (2 * (Airgap - Banding_Thickness)) + (4 * (((airgap - Banding_Thickness - Sleeve_Thickness) / 4) * 1)), DiaYoke=Shaft_Hole_Diameter, Length=0mm, SegAngle=0deg, Fractions=SymmetryFactor, HalfAxial=HalfAxial, InfoCore=0)
  Rotating_Band_in [vacuum] = user_primitive(RMxprt/Band.dll, DiaGap=DiaGap - (2 * (Airgap - Banding_Thickness)) + (4 * (((airgap - Banding_Thickness - Sleeve_Thickness) / 4) * 0.5)), DiaYoke=Shaft_Hole_Diameter, Length=0mm, SegAngle=0deg, Fractions=SymmetryFactor, HalfAxial=HalfAxial, InfoCore=0)
  Rotating_Band_out [vacuum] = user_primitive(RMxprt/Band.dll, DiaGap=DiaGap - (2 * (Airgap - Banding_Thickness)) + (4 * (((airgap - Banding_Thickness - Sleeve_Thickness) / 4) * 1.5)), DiaYoke=Shaft_Hole_Diameter, Length=0mm, SegAngle=0deg, Fractions=SymmetryFactor, HalfAxial=HalfAxial, InfoCore=0)
  Ph1_P1_C1_1 [Copper (Annealed)_20C] = user_primitive(RMxprt/LapCoil.dll, DiaGap=60mm, DiaYoke=DiaStatorYoke, Length=Stator_Lam_Length, Skew=StatorSkewAngle, Slots=SlotNumber_Stator, SlotType=SlotType_Stator, Hs0=Hs0_Stator, Hs1=Hs1_Stator, Hs2=13.614096mm, Bs0=Bs0_Stator, Bs1=3.1698874mm, Bs2=6.754547mm, Rs=Rs_Stator, FilletType=1, Layers=Layers, CoilPitch=-1, EndExt=WdgExt_F, SpanExt=SpanExt, BendAngle=0deg, SegAngle=15deg, LenRegion=Model_Length, InfoCoil=1)
  Ph1_P1_C1_1.rotate(axis=Z, angle=15deg)
  Ph2_P4_C1_1 [Copper (Annealed)_20C] = user_primitive(RMxprt/LapCoil.dll, DiaGap=60mm, DiaYoke=DiaStatorYoke, Length=Stator_Lam_Length, Skew=StatorSkewAngle, Slots=SlotNumber_Stator, SlotType=SlotType_Stator, Hs0=Hs0_Stator, Hs1=Hs1_Stator, Hs2=13.614096mm, Bs0=Bs0_Stator, Bs1=3.1698874mm, Bs2=6.754547mm, Rs=Rs_Stator, FilletType=1, Layers=Layers, CoilPitch=-1, EndExt=WdgExt_F, SpanExt=SpanExt, BendAngle=0deg, SegAngle=15deg, LenRegion=Model_Length, InfoCoil=1)
  Ph2_P4_C1_1.rotate(axis=Z, angle=45deg)
  Ph3_P3_C1_1 [Copper (Annealed)_20C] = user_primitive(RMxprt/LapCoil.dll, DiaGap=60mm, DiaYoke=DiaStatorYoke, Length=Stator_Lam_Length, Skew=StatorSkewAngle, Slots=SlotNumber_Stator, SlotType=SlotType_Stator, Hs0=Hs0_Stator, Hs1=Hs1_Stator, Hs2=13.614096mm, Bs0=Bs0_Stator, Bs1=3.1698874mm, Bs2=6.754547mm, Rs=Rs_Stator, FilletType=1, Layers=Layers, CoilPitch=-1, EndExt=WdgExt_F, SpanExt=SpanExt, BendAngle=0deg, SegAngle=15deg, LenRegion=Model_Length, InfoCoil=1)
  Ph3_P3_C1_1.rotate(axis=Z, angle=75deg)
  Ph1_P1_C1_2 [Copper (Annealed)_20C] = Ph1_P1_C1_1.separate_bodies()
  Ph2_P4_C1_2 [Copper (Annealed)_20C] = Ph2_P4_C1_1.separate_bodies()
  Ph3_P3_C1_2 [Copper (Annealed)_20C] = Ph3_P3_C1_1.separate_bodies()
  Band_Tool = user_primitive(RMxprt/Band.dll, DiaGap=1mm, DiaYoke=DiaOuter, Length=0mm, SegAngle=SegAngle, Fractions=SymmetryFactor, HalfAxial=HalfAxial, InfoCore=1)
  Whole_Region [vacuum] = user_primitive(RMxprt/Band.dll, DiaGap=DiaGap+Airgap, DiaYoke=DiaOuter, Length=0mm, SegAngle=SegAngle, Fractions=SymmetryFactor, HalfAxial=HalfAxial, InfoCore=100)
  Band_Tool_1 = Band_Tool.copy()
  Stator.subtract(Band_Tool_1)
  Band_Tool_2 = Band_Tool.copy()
  Shaft.subtract(Band_Tool_2)
  Band_Tool_3 = Band_Tool.copy()
  Rotor_1.subtract(Band_Tool_3)
  Band_Tool_4 = Band_Tool.copy()
  RotorAir.subtract(Band_Tool_4)
  Band_Tool_5 = Band_Tool.copy()
  1Magnet1N1_1_1.subtract(Band_Tool_5)
  Band_Tool_6 = Band_Tool.copy()
  RotorAir_1.subtract(Band_Tool_6)
  Band_Tool_7 = Band_Tool.copy()
  RotorAir_2.subtract(Band_Tool_7)
  Band_Tool_8 = Band_Tool.copy()
  1Magnet1S2_1_1.subtract(Band_Tool_8)
  Band_Tool_9 = Band_Tool.copy()
  RotorAir_3.subtract(Band_Tool_9)
  Band_Tool_10 = Band_Tool.copy()
  RotorAir_4.subtract(Band_Tool_10)
  Band_Tool_11 = Band_Tool.copy()
  1Magnet1N2_1_1.subtract(Band_Tool_11)
  Band_Tool_12 = Band_Tool.copy()
  RotorAir_5.subtract(Band_Tool_12)
  Band_Tool_13 = Band_Tool.copy()
  RotorAir_6.subtract(Band_Tool_13)
  Band_Tool_14 = Band_Tool.copy()
  1Magnet1S3_1_1.subtract(Band_Tool_14)
  Band_Tool_15 = Band_Tool.copy()
  RotorAir_7.subtract(Band_Tool_15)
  Band_Tool_16 = Band_Tool.copy()
  RotorAir_8.subtract(Band_Tool_16)
  Band_Tool_17 = Band_Tool.copy()
  RotorAir_9.subtract(Band_Tool_17)
  Band_Tool_18 = Band_Tool.copy()
  1Magnet1N3_1_1.subtract(Band_Tool_18)
  Band_Tool_19 = Band_Tool.copy()
  Rotating_Band_mid.subtract(Band_Tool_19)
  Band_Tool_20 = Band_Tool.copy()
  Rotating_Band_in.subtract(Band_Tool_20)
  Band_Tool_21 = Band_Tool.copy()
  Rotating_Band_out.subtract(Band_Tool_21)
  Band_Tool_22 = Band_Tool.copy()
  Ph1_P1_C1_1.subtract(Band_Tool_22)
  Band_Tool_23 = Band_Tool.copy()
  Ph2_P4_C1_1.subtract(Band_Tool_23)
  Band_Tool_24 = Band_Tool.copy()
  Ph3_P3_C1_1.subtract(Band_Tool_24)
  Band_Tool_25 = Band_Tool.copy()
  Ph1_P1_C1_2.subtract(Band_Tool_25)
  Band_Tool_26 = Band_Tool.copy()
  Ph2_P4_C1_2.subtract(Band_Tool_26)
  Band_Tool_27 = Band_Tool.copy()
  Ph3_P3_C1_2.subtract(Band_Tool_27)
  Whole_Region.subtract(Band_Tool)
  Boundary_Independent [vacuum] = user_primitive(RMxprt/Band.dll, DiaGap=DiaGap+Airgap, DiaYoke=DiaOuter, Length=0mm, SegAngle=SegAngle, Fractions=SymmetryFactor, HalfAxial=HalfAxial, InfoCore=2)
  Boundary_Dependent [vacuum] = user_primitive(RMxprt/Band.dll, DiaGap=DiaGap+Airgap, DiaYoke=DiaOuter, Length=0mm, SegAngle=SegAngle, Fractions=SymmetryFactor, HalfAxial=HalfAxial, InfoCore=3)
  Polyline1 = polyline(z=0mm, xy in mm: (29.3, 0) (20.718229, 20.718229) (1.7941076e-15, 29.3), AngularArc from point 0 over 3 centre=(0mm, 0mm, 0mm) angle=90deg plane=XY)
motion:
  MotionSetup1: Band Move_Type=Rotate Coordinate_System=Global Axis=Z Is_Positive=true InitPos=InitialPositionMD Angular_Velocity=MachineRPM Objects=Rotating_Band_out
  Moving1: Moving Objects=[Shaft, Rotor_1, RotorAir, 1Magnet1N1_1_1, RotorAir_1, RotorAir_2, 1Magnet1S2_1_1, RotorAir_3, RotorAir_4, 1Magnet1N2_1_1, RotorAir_5, RotorAir_6, 1Magnet1S3_1_1, RotorAir_7, RotorAir_8, RotorAir_9, 1Magnet1N3_1_1, Rotating_Band_mid, Rotating_Band_in, Polyline1]
boundaries and excitations:
  VectorPotential1: Vector Potential Edges=Whole_Region.edge(at (35.3553, 35.3553, 0)) Value=0
  Independent1: Independent Objects=Boundary_Independent
  Dependent1: Dependent Objects=Boundary_Dependent Independent=Independent1 SameAsMaster=false
  CT_Ph1_P1_C1_Go: Coil Objects=Ph1_P1_C1_1 Conductor_number=12 Winding=WG_Ph1 PolarityType=Positive
  CT_Ph1_P1_C1_Ret: Coil Objects=Ph1_P1_C1_2 Conductor_number=12 Winding=WG_Ph1 PolarityType=Negative
  CT_Ph2_P4_C1_Ret: Coil Objects=Ph2_P4_C1_1 Conductor_number=12 Winding=WG_Ph2 PolarityType=Negative
  CT_Ph2_P4_C1_Go: Coil Objects=Ph2_P4_C1_2 Conductor_number=12 Winding=WG_Ph2 PolarityType=Positive
  CT_Ph3_P3_C1_Go: Coil Objects=Ph3_P3_C1_1 Conductor_number=12 Winding=WG_Ph3 PolarityType=Positive
  CT_Ph3_P3_C1_Ret: Coil Objects=Ph3_P3_C1_2 Conductor_number=12 Winding=WG_Ph3 PolarityType=Negative
  1Magnet1N1_1_1: Current Objects=1Magnet1N1_1_1 Current=0A IsSolid=true IsPositive=true
  1Magnet1N2_1_1: Current Objects=1Magnet1N2_1_1 Current=0A IsSolid=true IsPositive=true
  1Magnet1N3_1_1: Current Objects=1Magnet1N3_1_1 Current=0A IsSolid=true IsPositive=true
  1Magnet1S2_1_1: Current Objects=1Magnet1S2_1_1 Current=0A IsSolid=true IsPositive=true
  1Magnet1S3_1_1: Current Objects=1Magnet1S3_1_1 Current=0A IsSolid=true IsPositive=true
  WG_Ph1: Winding Group Type=Current IsSolid=false Current="IPeak * sin((pi * MachineRPM/1rpm*NumPoles / 60*time + (360 - 0) / 360 * 2 * pi) + PhaseAdvance )" ParallelBranchesNum=ParallelPaths
  WG_Ph2: Winding Group Type=Current IsSolid=false Current="IPeak * sin((pi * MachineRPM/1rpm*NumPoles / 60*time + (360 - 120) / 360 * 2 * pi) + PhaseAdvance )" ParallelBranchesNum=ParallelPaths
  WG_Ph3: Winding Group Type=Current IsSolid=false Current="IPeak * sin((pi * MachineRPM/1rpm*NumPoles / 60*time + (360 - 240) / 360 * 2 * pi) + PhaseAdvance )" ParallelBranchesNum=ParallelPaths
  eddy effects on: 1Magnet1N1_1_1, 1Magnet1N2_1_1, 1Magnet1N3_1_1, 1Magnet1S2_1_1, 1Magnet1S3_1_1
  core loss on: Stator, Rotor_1
mesh:
  CylindricalGap1: CylindricalGap Objects=Rotating_Band_out
  Length1: LengthBased Objects=Stator NumMaxElem=250
  Length2: LengthBased RefineInside Objects=[Rotor_1, 1Magnet1N1_1_1, 1Magnet1S2_1_1, 1Magnet1N2_1_1, 1Magnet1S3_1_1, 1Magnet1N3_1_1] NumMaxElem=1000
  initial mesh: MeshMethod=AnsoftTAU
temperatures:
  Stator, Shaft, Rotor_1, RotorAir, RotorAir_1..RotorAir_9, Rotating_Band_mid, Rotating_Band_in, Rotating_Band_out, Ph1_P1_C1_1, Ph2_P4_C1_1, Ph3_P3_C1_1, Ph1_P1_C1_2, Ph2_P4_C1_2, Ph3_P3_C1_2, Whole_Region, Boundary_Independent, Boundary_Dependent, Polyline1: 22cel
  1Magnet1N1_1_1, 1Magnet1S2_1_1, 1Magnet1N2_1_1, 1Magnet1S3_1_1, 1Magnet1N3_1_1: 20cel
setups:
  Setup1: Transient NonlinearSolverResidual=0.0001 StopTime="NumTorqueCycles*120/(MachineRPM/1rpm*NumPoles) s" TimeStep="120/(MachineRPM/1rpm*NumPoles)/NumTorquePointsPerCycle s" OutputPerObjectCoreLoss OutputPerObjectSolidLoss SaveFieldsType=Custom SweepRanges{0ns to 0.0006s step 1e-05s} NumberSolveSteps=1 RangeStart=0s RangeEnd=0.1s InitialTimeStep="120/(MachineRPM/1rpm*NumPoles)/NumTorquePointsPerCycle s" MinTimeStep=0.001s MaxTimeStep=0.003s TimeStepErrTolerance=0.0001
output variables:
  ThetaED = ((pi * MachineRPM/1rpm*NumPoles / 60*time + (360 - 0) / 360 * 2 * pi)) + pi
  Id_peak = 2/3*(InputCurrent(WG_Ph1)*cos(ThetaED+360deg)+InputCurrent(WG_Ph2)*cos(ThetaED+240deg)+InputCurrent(WG_Ph3)*cos(ThetaED+120deg))
  Iq_peak = 2/3*(InputCurrent(WG_Ph1)*-sin(ThetaED+360deg)+InputCurrent(WG_Ph2)*-sin(ThetaED+240deg)+InputCurrent(WG_Ph3)*-sin(ThetaED+120deg))
  PsiD = 2/3*(FluxLinkage(WG_Ph1)*cos(ThetaED+360deg)+FluxLinkage(WG_Ph2)*cos(ThetaED+240deg)+FluxLinkage(WG_Ph3)*cos(ThetaED+120deg))
  PsiQ = 2/3*(FluxLinkage(WG_Ph1)*-sin(ThetaED+360deg)+FluxLinkage(WG_Ph2)*-sin(ThetaED+240deg)+FluxLinkage(WG_Ph3)*-sin(ThetaED+120deg))
  TorqueDQ = 3/2*NumPoles/2*(PsiD*Iq_peak - PsiQ*Id_peak)
field calculator expressions:
  BTang = Fundamental_Quantity(22) | Tangent | Dot
  Bradial = Fundamental_Quantity(22) | 2D_Normal | Dot
field plots:
  Mag_B1: B on Setup1 : Transient at Time=0s
reports:
  Induced Voltage Plots: InducedVoltage(WG_Ph1), InducedVoltage(WG_Ph2), InducedVoltage(WG_Ph3) vs Time on Setup1 : Transient
  Drive Current Plots: InputCurrent(WG_Ph1), InputCurrent(WG_Ph2), InputCurrent(WG_Ph3), Id_peak, Iq_peak vs Time on Setup1 : Transient
  Flux Linkage Plots: FluxLinkage(WG_Ph1), FluxLinkage(WG_Ph2), FluxLinkage(WG_Ph3), PsiD, PsiQ vs Time on Setup1 : Transient
  Torque Plots: Moving1.Torque vs Time on Setup1 : Transient
  Calculator Expressions Plot 1: Bradial vs Distance on Setup1 : Transient [Time=all]
  Calculator Expressions Plot 2: BTang vs Distance on Setup1 : Transient [Time=all]

design Motor-CAD 20p_24s_noload (Maxwell 2D, Transient, XY geometry, model units mm)
options: ModelDepth=Magnetic_Axial_Length
variables:
  DiaGap = 60mm
  DiaStatorYoke = 100mm
  DiaShaft = 19.7002mm
  DiaOuter = 100mm
  Airgap = 0.8mm
  StatorSkewAngle = 0deg
  Model_Length = 0mm
  Magnet_Length = 60mm
  Stator_Lam_Length = 0mm
  Rotor_Lam_Length = 0mm
  RotorDia = 58.4mm
  Rotor_Slices = 1
  SlotNumber_Stator = 24
  SlotType_Stator = 3
  Hs0_Stator = 1mm
  Hs1_Stator = 0.21328386mm
  Hs2_Stator = 13.614096mm
  Bs0_Stator = 2.25511mm
  Bs1_Stator = 3.1698874mm
  Bs2_Stator = 6.754547mm
  Rs_Stator = 1mm
  Magnetic_Axial_Length = 60mm
  Layers = 1
  ParallelPaths = 4
  WdgExt_F = 4mm
  SpanExt = 14mm
  HalfAxial = 0
  SymmetryFactor = 4
  SegAngle = 0deg
  NumPoles = 20
  Magnet_Axial_Offset = 0mm
  Axial_Segments = 2
  Shaft_Hole_Diameter = 0mm
  Sleeve_Thickness = 0mm
  Banding_Thickness = 0mm
  IPeak = 0A
  PhaseAdvance = 0deg
  MachineRPM = 10000rpm
  NumTorqueCycles = 1
  NumTorquePointsPerCycle = 60
  DriveOffsetED = 60deg
  InitialPositionMD = DriveOffsetED / (NumPoles/2)
geometry:
  Stator [M250-35A_20C] = polyline(z=0mm, xy in mm: (50, 0) (35.355339, 35.355339) (3.061617e-15, 50) (0, 30) (1.3990774, 29.967359) (2.7951102, 29.869505) (2.9256366, 30.86095) (2.5, 31.132111) (2.5, 44.863682) (2.8209484, 45.597773) (3.5777778, 45.860653) (6.0042046, 45.606464) (8.413742, 45.223986) (9.0767449, 44.774182) (9.196761, 43.982038) (5.6427686, 30.718357) (5.1614538, 30.566599) (5.0309276, 29.575155) (7.7645712, 28.977775) (10.430666, 28.128299) (10.81335, 29.052179) (10.472398, 29.424262) (14.02639, 42.687942) (14.526399, 43.313951) (15.325478, 43.371992) (17.603438, 42.498459) (19.83188, 41.50538) (20.355873, 40.899304) (20.266778, 40.103089) (13.400992, 28.211199) (12.8968, 28.189185) (12.514116, 27.265306) (15, 25.980762) (17.355389, 24.470196) (17.964151, 25.263549) (17.731119, 25.711199) (24.596905, 37.603089) (25.241899, 38.078356) (26.028773, 37.927602) (28.003026, 36.494254) (29.898508, 34.95825) (30.247783, 34.237207) (29.955647, 33.491181) (20.24596, 23.781494) (19.75325, 23.890725) (19.144488, 23.097371) (21.213203, 21.213204) (23.097371, 19.144489) (23.890725, 19.75325) (23.781494, 20.24596) (33.491181, 29.955647) (34.237206, 30.247783) (34.95825, 29.898508) (36.494254, 28.003026) (37.927601, 26.028773) (38.078356, 25.2419) (37.603089, 24.596905) (25.711199, 17.731119) (25.263549, 17.964151) (24.470195, 17.355389) (25.980762, 15) (27.265306, 12.514116) (28.189185, 12.8968) (28.211199, 13.400992) (40.103089, 20.266778) (40.899304, 20.355874) (41.50538, 19.83188) (42.498458, 17.603438) (43.371992, 15.325479) (43.313952, 14.526399) (42.687942, 14.02639) (29.424262, 10.472398) (29.052179, 10.81335) (28.128299, 10.430666) (28.977775, 7.7645714) (29.575155, 5.0309277) (30.566599, 5.1614538) (30.718357, 5.6427686) (43.982037, 9.1967609) (44.774182, 9.0767452) (45.223986, 8.4137425) (45.606464, 6.0042048) (45.860653, 3.5777778) (45.597773, 2.8209484) (44.863682, 2.5) (31.132111, 2.5) (30.86095, 2.9256366) (29.869505, 2.7951104) (29.967359, 1.3990774) (30, -2.5868196e-12) (50, 0), closed, covered, AngularArc from point 0 over 3 centre=(0mm, 0mm, 0mm) angle=90deg plane=XY, AngularArc from point 3 over 3 centre=(0mm, 0mm, 0mm) angle=-5.346021deg plane=XY, AngularArc from point 8 over 3 centre=(3.5mm, 44.863682mm, 0mm) angle=-94.460844deg plane=XY, AngularArc from point 10 over 3 centre=(0mm, 0mm, 0mm) angle=-6.078312deg plane=XY, AngularArc from point 12 over 3 centre=(8.2308351mm, 44.240856mm, 0mm) angle=-94.460844deg plane=XY, AngularArc from point 17 over 3 centre=(0mm, 0mm, 0mm) angle=-10.692042deg plane=XY, AngularArc from point 22 over 3 centre=(14.992316mm, 42.429123mm, 0mm) angle=-94.460844deg plane=XY, AngularArc from point 24 over 3 centre=(0mm, 0mm, 0mm) angle=-6.078312deg plane=XY, AngularArc from point 26 over 3 centre=(19.400752mm, 40.603089mm, 0mm) angle=-94.460844deg plane=XY, AngularArc from point 31 over 3 centre=(0mm, 0mm, 0mm) angle=-10.692042deg plane=XY, AngularArc from point 36 over 3 centre=(25.46293mm, 37.103089mm, 0mm) angle=-94.460844deg plane=XY, AngularArc from point 38 over 3 centre=(0mm, 0mm, 0mm) angle=-6.078312deg plane=XY, AngularArc from point 40 over 3 centre=(29.24854mm, 34.198288mm, 0mm) angle=-94.460844deg plane=XY, AngularArc from point 45 over 3 centre=(0mm, 0mm, 0mm) angle=-10.692042deg plane=XY, AngularArc from point 50 over 3 centre=(34.198288mm, 29.24854mm, 0mm) angle=-94.460844deg plane=XY, AngularArc from point 52 over 3 centre=(0mm, 0mm, 0mm) angle=-6.078312deg plane=XY, AngularArc from point 54 over 3 centre=(37.103089mm, 25.46293mm, 0mm) angle=-94.460844deg plane=XY, AngularArc from point 59 over 3 centre=(0mm, 0mm, 0mm) angle=-10.692042deg plane=XY, AngularArc from point 64 over 3 centre=(40.603089mm, 19.400752mm, 0mm) angle=-94.460844deg plane=XY, AngularArc from point 66 over 3 centre=(0mm, 0mm, 0mm) angle=-6.078312deg plane=XY, AngularArc from point 68 over 3 centre=(42.429123mm, 14.992316mm, 0mm) angle=-94.460844deg plane=XY, AngularArc from point 73 over 3 centre=(0mm, 0mm, 0mm) angle=-10.692042deg plane=XY, AngularArc from point 78 over 3 centre=(44.240856mm, 8.2308351mm, 0mm) angle=-94.460844deg plane=XY, AngularArc from point 80 over 3 centre=(0mm, 0mm, 0mm) angle=-6.0783126deg plane=XY, AngularArc from point 82 over 3 centre=(44.863682mm, 3.5mm, 0mm) angle=-94.460844deg plane=XY, AngularArc from point 87 over 3 centre=(0mm, 0mm, 0mm) angle=-5.3460212deg plane=XY)
  Shaft [vacuum] = polyline(z=0mm, xy in mm: (9.8501, 0) (6.9650725, 6.9650725) (6.0314467e-16, 9.8501) (0, 0) (9.8501, 0), closed, covered, AngularArc from point 0 over 3 centre=(0mm, 0mm, 0mm) angle=90deg plane=XY)
  Rotor_1 [M250-35A_20C] = polyline(z=0mm, xy in mm: (9.8501, 2.1871616e-15) (26.2, 0) (18.526198, 18.526198) (1.6042873e-15, 26.2) (0, 9.8501) (6.9650725, 6.9650725) (9.8501, 2.1871616e-15), closed, covered, AngularArc from point 1 over 3 centre=(0mm, 0mm, 0mm) angle=90deg plane=XY, AngularArc from point 4 over 3 centre=(0mm, 0mm, 0mm) angle=-90deg plane=XY)
  RotorAir [vacuum] = polyline(z=0mm, xy in mm: (26.2, -5.6035732e-13) (29.2, 0) (29.199722, 0.12740863) (29.198888, 0.25481484) (26.199002, 0.22863523) (26.199751, 0.1143187) (26.2, -5.6035732e-13), closed, covered, AngularArc from point 1 over 3 centre=(0mm, 0mm, 0mm) angle=0.5deg plane=XY, AngularArc from point 4 over 3 centre=(0mm, 0mm, 0mm) angle=-0.5deg plane=XY)
  coordinate_system CS_1Magnet1N1_1_1 = origin=(27.358967mm, 4.3332347mm, 0mm) x=(1.3728868mm, 0.21744391mm, 0mm) y=(-0.21744391mm, 1.3728868mm, 0mm)
  1Magnet1N1_1_1 [N48H_AM, oriented by CS_1Magnet1N1_1_1] = polyline(z=0mm, xy in mm: (26.199002, 0.22863523) (29.198888, 0.25481484) (28.8405, 4.5678864) (27.848535, 8.7806093) (24.987384, 7.8784919) (25.877435, 4.098583) (26.199002, 0.22863523), closed, covered, AngularArc from point 1 over 3 centre=(0mm, 0mm, 0mm) angle=17deg plane=XY, AngularArc from point 4 over 3 centre=(0mm, 0mm, 0mm) angle=-17deg plane=XY)
  RotorAir_1 [vacuum] = polyline(z=0mm, xy in mm: (24.987384, 7.8784919) (27.848535, 8.7806093) (27.809957, 8.9020375) (27.77085, 9.0232962) (24.917681, 8.0962453) (24.95277, 7.9874446) (24.987384, 7.8784919), closed, covered, AngularArc from point 1 over 3 centre=(0mm, 0mm, 0mm) angle=0.5deg plane=XY, AngularArc from point 4 over 3 centre=(0mm, 0mm, 0mm) angle=-0.5deg plane=XY)
  RotorAir_2 [vacuum] = polyline(z=0mm, xy in mm: (24.917681, 8.0962453) (27.77085, 9.0232962) (27.731214, 9.1443831) (27.691051, 9.265296) (24.84608, 8.313382) (24.882117, 8.2048917) (24.917681, 8.0962453), closed, covered, AngularArc from point 1 over 3 centre=(0mm, 0mm, 0mm) angle=0.5deg plane=XY, AngularArc from point 4 over 3 centre=(0mm, 0mm, 0mm) angle=-0.5deg plane=XY)
  coordinate_system CS_1Magnet1S2_1_1 = origin=(24.68088072mm, 12.575537mm, 0mm) x=(-1.2384991mm, -0.63104679mm, 0mm) y=(0.63104679mm, -1.2384991mm, 0mm)
  1Magnet1S2_1_1 [N48H_AM, oriented by CS_1Magnet1S2_1_1] = polyline(z=0mm, xy in mm: (24.84608, 8.313382) (27.691051, 9.265296) (26.017391, 13.256523) (23.772173, 16.956526) (21.329827, 15.214417) (23.344371, 11.894551) (24.84608, 8.313382), closed, covered, AngularArc from point 1 over 3 centre=(0mm, 0mm, 0mm) angle=17deg plane=XY, AngularArc from point 4 over 3 centre=(0mm, 0mm, 0mm) angle=-17deg plane=XY)
  RotorAir_3 [vacuum] = polyline(z=0mm, xy in mm: (21.329827, 15.214417) (23.772173, 16.956526) (23.69796, 17.06009) (23.623296, 17.163329) (21.196245, 15.399974) (21.263238, 15.307341) (21.329827, 15.214417), closed, covered, AngularArc from point 1 over 3 centre=(0mm, 0mm, 0mm) angle=0.5deg plane=XY, AngularArc from point 4 over 3 centre=(0mm, 0mm, 0mm) angle=-0.5deg plane=XY)
  RotorAir_4 [vacuum] = polyline(z=0mm, xy in mm: (21.196245, 15.399974) (23.623296, 17.163329) (23.548182, 17.266242) (23.47262, 17.368825) (21.06105, 15.584357) (21.128849, 15.492313) (21.196245, 15.399974), closed, covered, AngularArc from point 1 over 3 centre=(0mm, 0mm, 0mm) angle=0.5deg plane=XY, AngularArc from point 4 over 3 centre=(0mm, 0mm, 0mm) angle=-0.5deg plane=XY)
  coordinate_system CS_1Magnet1N2_1_1 = origin=(19.586858mm, 19.586858mm, 0mm) x=(0.98287843mm, 0.98287843mm, 0mm) y=(-0.98287843mm, 0.98287843mm, 0mm)
  1Magnet1N2_1_1 [N48H_AM, oriented by CS_1Magnet1N2_1_1] = polyline(z=0mm, xy in mm: (21.06105, 15.584357) (23.47262033, 17.368825) (20.647518, 20.647518) (17.368825, 23.47262) (15.584357, 21.06105) (18.526198, 18.526198) (21.06105, 15.584357), closed, covered, AngularArc from point 1 over 3 centre=(0mm, 0mm, 0mm) angle=17deg plane=XY, AngularArc from point 4 over 3 centre=(0mm, 0mm, 0mm) angle=-17deg plane=XY)
  RotorAir_5 [vacuum] = polyline(z=0mm, xy in mm: (15.584357, 21.06105) (17.368825, 23.47262033) (17.266242, 23.548182) (17.163329, 23.623296) (15.399974, 21.196245) (15.492313, 21.128849) (15.584357, 21.06105), closed, covered, AngularArc from point 1 over 3 centre=(0mm, 0mm, 0mm) angle=0.5deg plane=XY, AngularArc from point 4 over 3 centre=(0mm, 0mm, 0mm) angle=-0.5deg plane=XY)
  RotorAir_6 [vacuum] = polyline(z=0mm, xy in mm: (15.399974, 21.196245) (17.163329, 23.623296) (17.06009, 23.69796) (16.956526, 23.772173) (15.214417, 21.329827) (15.307341, 21.263238) (15.399974, 21.196245), closed, covered, AngularArc from point 1 over 3 centre=(0mm, 0mm, 0mm) angle=0.5deg plane=XY, AngularArc from point 4 over 3 centre=(0mm, 0mm, 0mm) angle=-0.5deg plane=XY)
  coordinate_system CS_1Magnet1S3_1_1 = origin=(12.575537mm, 24.68088072mm, 0mm) x=(-0.63104679mm, -1.2384991mm, 0mm) y=(1.2384991mm, -0.63104679mm, 0mm)
  1Magnet1S3_1_1 [N48H_AM, oriented by CS_1Magnet1S3_1_1] = polyline(z=0mm, xy in mm: (15.214417, 21.329827) (16.956526, 23.772173) (13.256523, 26.017391) (9.265296, 27.691051) (8.313382, 24.84608) (11.894551, 23.344371) (15.214417, 21.329827), closed, covered, AngularArc from point 1 over 3 centre=(0mm, 0mm, 0mm) angle=17deg plane=XY, AngularArc from point 4 over 3 centre=(0mm, 0mm, 0mm) angle=-17deg plane=XY)
  RotorAir_7 [vacuum] = polyline(z=0mm, xy in mm: (8.313382, 24.84608) (9.265296, 27.691051) (9.1443831, 27.731214) (9.0232962, 27.77085) (8.0962453, 24.917681) (8.2048917, 24.882117) (8.313382, 24.84608), closed, covered, AngularArc from point 1 over 3 centre=(0mm, 0mm, 0mm) angle=0.5deg plane=XY, AngularArc from point 4 over 3 centre=(0mm, 0mm, 0mm) angle=-0.5deg plane=XY)
  RotorAir_8 [vacuum] = polyline(z=0mm, xy in mm: (8.0962453, 24.917681) (9.0232962, 27.77085) (8.9020375, 27.809957) (8.7806093, 27.848535) (7.8784919, 24.987384) (7.9874446, 24.95277) (8.0962453, 24.917681), closed, covered, AngularArc from point 1 over 3 centre=(0mm, 0mm, 0mm) angle=0.5deg plane=XY, AngularArc from point 4 over 3 centre=(0mm, 0mm, 0mm) angle=-0.5deg plane=XY)
  RotorAir_9 [vacuum] = polyline(z=0mm, xy in mm: (0, 26.2) (0.1143187, 26.199751) (0.22863523, 26.199002) (0.25481484, 29.198888) (0.12740863, 29.199722) (2.5823788e-13, 29.2) (0, 26.2), closed, covered, AngularArc from point 0 over 3 centre=(0mm, 0mm, 0mm) angle=-0.5deg plane=XY, AngularArc from point 3 over 3 centre=(0mm, 0mm, 0mm) angle=0.5deg plane=XY)
  coordinate_system CS_1Magnet1N3_1_1 = origin=(4.3332347mm, 27.358967mm, 0mm) x=(0.21744391mm, 1.3728868mm, 0mm) y=(-1.3728868mm, 0.21744391mm, 0mm)
  1Magnet1N3_1_1 [N48H_AM, oriented by CS_1Magnet1N3_1_1] = polyline(z=0mm, xy in mm: (7.8784919, 24.987384) (8.7806093, 27.848535) (4.5678864, 28.8405) (0.25481484, 29.198888) (0.22863523, 26.199002) (4.098583, 25.877435) (7.8784919, 24.987384), closed, covered, AngularArc from point 1 over 3 centre=(0mm, 0mm, 0mm) angle=17deg plane=XY, AngularArc from point 4 over 3 centre=(0mm, 0mm, 0mm) angle=-17deg plane=XY)
  Rotating_Band_mid [vacuum] = user_primitive(RMxprt/Band.dll, DiaGap=DiaGap - (2 * (Airgap - Banding_Thickness)) + (4 * (((airgap - Banding_Thickness - Sleeve_Thickness) / 4) * 1)), DiaYoke=Shaft_Hole_Diameter, Length=0mm, SegAngle=0deg, Fractions=SymmetryFactor, HalfAxial=HalfAxial, InfoCore=0)
  Rotating_Band_in [vacuum] = user_primitive(RMxprt/Band.dll, DiaGap=DiaGap - (2 * (Airgap - Banding_Thickness)) + (4 * (((airgap - Banding_Thickness - Sleeve_Thickness) / 4) * 0.5)), DiaYoke=Shaft_Hole_Diameter, Length=0mm, SegAngle=0deg, Fractions=SymmetryFactor, HalfAxial=HalfAxial, InfoCore=0)
  Rotating_Band_out [vacuum] = user_primitive(RMxprt/Band.dll, DiaGap=DiaGap - (2 * (Airgap - Banding_Thickness)) + (4 * (((airgap - Banding_Thickness - Sleeve_Thickness) / 4) * 1.5)), DiaYoke=Shaft_Hole_Diameter, Length=0mm, SegAngle=0deg, Fractions=SymmetryFactor, HalfAxial=HalfAxial, InfoCore=0)
  Ph1_P1_C1_1 [Copper (Annealed)_20C] = user_primitive(RMxprt/LapCoil.dll, DiaGap=60mm, DiaYoke=DiaStatorYoke, Length=Stator_Lam_Length, Skew=StatorSkewAngle, Slots=SlotNumber_Stator, SlotType=SlotType_Stator, Hs0=Hs0_Stator, Hs1=Hs1_Stator, Hs2=13.614096mm, Bs0=Bs0_Stator, Bs1=3.1698874mm, Bs2=6.754547mm, Rs=Rs_Stator, FilletType=1, Layers=Layers, CoilPitch=-1, EndExt=WdgExt_F, SpanExt=SpanExt, BendAngle=0deg, SegAngle=15deg, LenRegion=Model_Length, InfoCoil=1)
  Ph1_P1_C1_1.rotate(axis=Z, angle=15deg)
  Ph2_P4_C1_1 [Copper (Annealed)_20C] = user_primitive(RMxprt/LapCoil.dll, DiaGap=60mm, DiaYoke=DiaStatorYoke, Length=Stator_Lam_Length, Skew=StatorSkewAngle, Slots=SlotNumber_Stator, SlotType=SlotType_Stator, Hs0=Hs0_Stator, Hs1=Hs1_Stator, Hs2=13.614096mm, Bs0=Bs0_Stator, Bs1=3.1698874mm, Bs2=6.754547mm, Rs=Rs_Stator, FilletType=1, Layers=Layers, CoilPitch=-1, EndExt=WdgExt_F, SpanExt=SpanExt, BendAngle=0deg, SegAngle=15deg, LenRegion=Model_Length, InfoCoil=1)
  Ph2_P4_C1_1.rotate(axis=Z, angle=45deg)
  Ph3_P3_C1_1 [Copper (Annealed)_20C] = user_primitive(RMxprt/LapCoil.dll, DiaGap=60mm, DiaYoke=DiaStatorYoke, Length=Stator_Lam_Length, Skew=StatorSkewAngle, Slots=SlotNumber_Stator, SlotType=SlotType_Stator, Hs0=Hs0_Stator, Hs1=Hs1_Stator, Hs2=13.614096mm, Bs0=Bs0_Stator, Bs1=3.1698874mm, Bs2=6.754547mm, Rs=Rs_Stator, FilletType=1, Layers=Layers, CoilPitch=-1, EndExt=WdgExt_F, SpanExt=SpanExt, BendAngle=0deg, SegAngle=15deg, LenRegion=Model_Length, InfoCoil=1)
  Ph3_P3_C1_1.rotate(axis=Z, angle=75deg)
  Ph1_P1_C1_2 [Copper (Annealed)_20C] = Ph1_P1_C1_1.separate_bodies()
  Ph2_P4_C1_2 [Copper (Annealed)_20C] = Ph2_P4_C1_1.separate_bodies()
  Ph3_P3_C1_2 [Copper (Annealed)_20C] = Ph3_P3_C1_1.separate_bodies()
  Band_Tool = user_primitive(RMxprt/Band.dll, DiaGap=1mm, DiaYoke=DiaOuter, Length=0mm, SegAngle=SegAngle, Fractions=SymmetryFactor, HalfAxial=HalfAxial, InfoCore=1)
  Whole_Region [vacuum] = user_primitive(RMxprt/Band.dll, DiaGap=DiaGap+Airgap, DiaYoke=DiaOuter, Length=0mm, SegAngle=SegAngle, Fractions=SymmetryFactor, HalfAxial=HalfAxial, InfoCore=100)
  Band_Tool_1 = Band_Tool.copy()
  Stator.subtract(Band_Tool_1)
  Band_Tool_2 = Band_Tool.copy()
  Shaft.subtract(Band_Tool_2)
  Band_Tool_3 = Band_Tool.copy()
  Rotor_1.subtract(Band_Tool_3)
  Band_Tool_4 = Band_Tool.copy()
  RotorAir.subtract(Band_Tool_4)
  Band_Tool_5 = Band_Tool.copy()
  1Magnet1N1_1_1.subtract(Band_Tool_5)
  Band_Tool_6 = Band_Tool.copy()
  RotorAir_1.subtract(Band_Tool_6)
  Band_Tool_7 = Band_Tool.copy()
  RotorAir_2.subtract(Band_Tool_7)
  Band_Tool_8 = Band_Tool.copy()
  1Magnet1S2_1_1.subtract(Band_Tool_8)
  Band_Tool_9 = Band_Tool.copy()
  RotorAir_3.subtract(Band_Tool_9)
  Band_Tool_10 = Band_Tool.copy()
  RotorAir_4.subtract(Band_Tool_10)
  Band_Tool_11 = Band_Tool.copy()
  1Magnet1N2_1_1.subtract(Band_Tool_11)
  Band_Tool_12 = Band_Tool.copy()
  RotorAir_5.subtract(Band_Tool_12)
  Band_Tool_13 = Band_Tool.copy()
  RotorAir_6.subtract(Band_Tool_13)
  Band_Tool_14 = Band_Tool.copy()
  1Magnet1S3_1_1.subtract(Band_Tool_14)
  Band_Tool_15 = Band_Tool.copy()
  RotorAir_7.subtract(Band_Tool_15)
  Band_Tool_16 = Band_Tool.copy()
  RotorAir_8.subtract(Band_Tool_16)
  Band_Tool_17 = Band_Tool.copy()
  RotorAir_9.subtract(Band_Tool_17)
  Band_Tool_18 = Band_Tool.copy()
  1Magnet1N3_1_1.subtract(Band_Tool_18)
  Band_Tool_19 = Band_Tool.copy()
  Rotating_Band_mid.subtract(Band_Tool_19)
  Band_Tool_20 = Band_Tool.copy()
  Rotating_Band_in.subtract(Band_Tool_20)
  Band_Tool_21 = Band_Tool.copy()
  Rotating_Band_out.subtract(Band_Tool_21)
  Band_Tool_22 = Band_Tool.copy()
  Ph1_P1_C1_1.subtract(Band_Tool_22)
  Band_Tool_23 = Band_Tool.copy()
  Ph2_P4_C1_1.subtract(Band_Tool_23)
  Band_Tool_24 = Band_Tool.copy()
  Ph3_P3_C1_1.subtract(Band_Tool_24)
  Band_Tool_25 = Band_Tool.copy()
  Ph1_P1_C1_2.subtract(Band_Tool_25)
  Band_Tool_26 = Band_Tool.copy()
  Ph2_P4_C1_2.subtract(Band_Tool_26)
  Band_Tool_27 = Band_Tool.copy()
  Ph3_P3_C1_2.subtract(Band_Tool_27)
  Whole_Region.subtract(Band_Tool)
  Boundary_Independent [vacuum] = user_primitive(RMxprt/Band.dll, DiaGap=DiaGap+Airgap, DiaYoke=DiaOuter, Length=0mm, SegAngle=SegAngle, Fractions=SymmetryFactor, HalfAxial=HalfAxial, InfoCore=2)
  Boundary_Dependent [vacuum] = user_primitive(RMxprt/Band.dll, DiaGap=DiaGap+Airgap, DiaYoke=DiaOuter, Length=0mm, SegAngle=SegAngle, Fractions=SymmetryFactor, HalfAxial=HalfAxial, InfoCore=3)
  Polyline1 = polyline(z=0mm, xy in mm: (29.3, 0) (20.718229, 20.718229) (1.7941076e-15, 29.3), AngularArc from point 0 over 3 centre=(0mm, 0mm, 0mm) angle=90deg plane=XY)
motion:
  MotionSetup1: Band Move_Type=Rotate Coordinate_System=Global Axis=Z Is_Positive=true InitPos=InitialPositionMD Angular_Velocity=MachineRPM Objects=Rotating_Band_out
  Moving1: Moving Objects=[Shaft, Rotor_1, RotorAir, 1Magnet1N1_1_1, RotorAir_1, RotorAir_2, 1Magnet1S2_1_1, RotorAir_3, RotorAir_4, 1Magnet1N2_1_1, RotorAir_5, RotorAir_6, 1Magnet1S3_1_1, RotorAir_7, RotorAir_8, RotorAir_9, 1Magnet1N3_1_1, Rotating_Band_mid, Rotating_Band_in, Polyline1]
boundaries and excitations:
  VectorPotential1: Vector Potential Edges=Whole_Region.edge(at (35.3553, 35.3553, 0)) Value=0
  Independent1: Independent Objects=Boundary_Independent
  Dependent1: Dependent Objects=Boundary_Dependent Independent=Independent1 SameAsMaster=false
  CT_Ph1_P1_C1_Go: Coil Objects=Ph1_P1_C1_1 Conductor_number=12 Winding=WG_Ph1 PolarityType=Positive
  CT_Ph1_P1_C1_Ret: Coil Objects=Ph1_P1_C1_2 Conductor_number=12 Winding=WG_Ph1 PolarityType=Negative
  CT_Ph2_P4_C1_Ret: Coil Objects=Ph2_P4_C1_1 Conductor_number=12 Winding=WG_Ph2 PolarityType=Negative
  CT_Ph2_P4_C1_Go: Coil Objects=Ph2_P4_C1_2 Conductor_number=12 Winding=WG_Ph2 PolarityType=Positive
  CT_Ph3_P3_C1_Go: Coil Objects=Ph3_P3_C1_1 Conductor_number=12 Winding=WG_Ph3 PolarityType=Positive
  CT_Ph3_P3_C1_Ret: Coil Objects=Ph3_P3_C1_2 Conductor_number=12 Winding=WG_Ph3 PolarityType=Negative
  1Magnet1N1_1_1: Current Objects=1Magnet1N1_1_1 Current=0A IsSolid=true IsPositive=true
  1Magnet1N2_1_1: Current Objects=1Magnet1N2_1_1 Current=0A IsSolid=true IsPositive=true
  1Magnet1N3_1_1: Current Objects=1Magnet1N3_1_1 Current=0A IsSolid=true IsPositive=true
  1Magnet1S2_1_1: Current Objects=1Magnet1S2_1_1 Current=0A IsSolid=true IsPositive=true
  1Magnet1S3_1_1: Current Objects=1Magnet1S3_1_1 Current=0A IsSolid=true IsPositive=true
  WG_Ph1: Winding Group Type=Current IsSolid=false Current="IPeak * sin((pi * MachineRPM/1rpm*NumPoles / 60*time + (360 - 0) / 360 * 2 * pi) + PhaseAdvance )" ParallelBranchesNum=ParallelPaths
  WG_Ph2: Winding Group Type=Current IsSolid=false Current="IPeak * sin((pi * MachineRPM/1rpm*NumPoles / 60*time + (360 - 120) / 360 * 2 * pi) + PhaseAdvance )" ParallelBranchesNum=ParallelPaths
  WG_Ph3: Winding Group Type=Current IsSolid=false Current="IPeak * sin((pi * MachineRPM/1rpm*NumPoles / 60*time + (360 - 240) / 360 * 2 * pi) + PhaseAdvance )" ParallelBranchesNum=ParallelPaths
  eddy effects on: 1Magnet1N1_1_1, 1Magnet1N2_1_1, 1Magnet1N3_1_1, 1Magnet1S2_1_1, 1Magnet1S3_1_1
  core loss on: Stator, Rotor_1
mesh:
  CylindricalGap1: CylindricalGap Objects=Rotating_Band_out
  Length1: LengthBased Objects=Stator NumMaxElem=250
  Length2: LengthBased RefineInside Objects=[Rotor_1, 1Magnet1N1_1_1, 1Magnet1S2_1_1, 1Magnet1N2_1_1, 1Magnet1S3_1_1, 1Magnet1N3_1_1] NumMaxElem=1000
  initial mesh: MeshMethod=AnsoftTAU
temperatures:
  Stator, Shaft, Rotor_1, RotorAir, RotorAir_1..RotorAir_9, Rotating_Band_mid, Rotating_Band_in, Rotating_Band_out, Ph1_P1_C1_1, Ph2_P4_C1_1, Ph3_P3_C1_1, Ph1_P1_C1_2, Ph2_P4_C1_2, Ph3_P3_C1_2, Whole_Region, Boundary_Independent, Boundary_Dependent, Polyline1: 22cel
  1Magnet1N1_1_1, 1Magnet1S2_1_1, 1Magnet1N2_1_1, 1Magnet1S3_1_1, 1Magnet1N3_1_1: 20cel
setups:
  Setup1: Transient NonlinearSolverResidual=0.0001 StopTime="NumTorqueCycles*120/(MachineRPM/1rpm*NumPoles) s" TimeStep="120/(MachineRPM/1rpm*NumPoles)/NumTorquePointsPerCycle s" OutputPerObjectCoreLoss OutputPerObjectSolidLoss SaveFieldsType=Custom SweepRanges{0ns to 0.0006s step 1e-05s} NumberSolveSteps=1 RangeStart=0s RangeEnd=0.1s InitialTimeStep="120/(MachineRPM/1rpm*NumPoles)/NumTorquePointsPerCycle s" MinTimeStep=0.001s MaxTimeStep=0.003s TimeStepErrTolerance=0.0001
output variables:
  ThetaED = ((pi * MachineRPM/1rpm*NumPoles / 60*time + (360 - 0) / 360 * 2 * pi)) + pi
  Id_peak = 2/3*(InputCurrent(WG_Ph1)*cos(ThetaED+360deg)+InputCurrent(WG_Ph2)*cos(ThetaED+240deg)+InputCurrent(WG_Ph3)*cos(ThetaED+120deg))
  Iq_peak = 2/3*(InputCurrent(WG_Ph1)*-sin(ThetaED+360deg)+InputCurrent(WG_Ph2)*-sin(ThetaED+240deg)+InputCurrent(WG_Ph3)*-sin(ThetaED+120deg))
  PsiD = 2/3*(FluxLinkage(WG_Ph1)*cos(ThetaED+360deg)+FluxLinkage(WG_Ph2)*cos(ThetaED+240deg)+FluxLinkage(WG_Ph3)*cos(ThetaED+120deg))
  PsiQ = 2/3*(FluxLinkage(WG_Ph1)*-sin(ThetaED+360deg)+FluxLinkage(WG_Ph2)*-sin(ThetaED+240deg)+FluxLinkage(WG_Ph3)*-sin(ThetaED+120deg))
  TorqueDQ = 3/2*NumPoles/2*(PsiD*Iq_peak - PsiQ*Id_peak)
field calculator expressions:
  BTang = Fundamental_Quantity(22) | Tangent | Dot
  Bradial = Fundamental_Quantity(22) | 2D_Normal | Dot
reports:
  Induced Voltage Plots: InducedVoltage(WG_Ph1), InducedVoltage(WG_Ph2), InducedVoltage(WG_Ph3) vs Time on Setup1 : Transient
  Drive Current Plots: InputCurrent(WG_Ph1), InputCurrent(WG_Ph2), InputCurrent(WG_Ph3), Id_peak, Iq_peak vs Time on Setup1 : Transient
  Flux Linkage Plots: FluxLinkage(WG_Ph1), FluxLinkage(WG_Ph2), FluxLinkage(WG_Ph3), PsiD, PsiQ vs Time on Setup1 : Transient
  Torque Plots: Moving1.Torque vs Time on Setup1 : Transient
  Br: Bradial vs Distance on Setup1 : Transient [Time=0ns]
  Bt: BTang vs Distance on Setup1 : Transient [Time=0ns]
  FFT Br: FFT Bradial vs FFT Distance; markers m1 at 65.182391, m2 at 43.454927
  FFT Bt: FFT BTang vs FFT Distance
   Plot 1: InducedVoltage(WG_Ph1)-InducedVoltage(WG_Ph2), InducedVoltage(WG_Ph3)-InducedVoltage(WG_Ph1), InducedVoltage(WG_Ph2)-InducedVoltage(WG_Ph3) vs Time on Setup1 : Transient
